ADE simulation setup
Run mode: Single Run, Sweeps and Corners
Tests:
  PTM_14nm_FKK:SRAM:1: PTM_14nm_FKK/SRAM/schematic, simulator spectre
