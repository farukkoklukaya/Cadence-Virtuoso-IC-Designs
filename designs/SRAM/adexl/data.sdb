ADE simulation setup
Run mode: Single Run, Sweeps and Corners
Tests:
  PTM_14nm_FKK:SRAM:1: PTM_14nm_FKK/SRAM/schematic, simulator spectre
Global variables:
  Vdd = 1.8
Corners:
  model folders: /home/work/gpdk045_v_5_0/models/spectre
  C0: Vdd=1.8,1; gpdk045.scs[ff, fs, ss, sf]
