ADE simulation setup
Test PTM_14nm_FKK:LED_Driver_Drived_Vt_Referenced:1: PTM_14nm_FKK/LED_Driver_Drived_Vt_Referenced/schematic, simulator spectre
  Models: /home/work/PTM_14nm_FKK/tsmc035.lib, /home/work/PTM_14nm_FKK/LED_Driver_Drived_Vt_Referenced/led_model.scs
  Temperature: 27
  Analysis tran: stop=10u errpreset=moderate
  Signals: /net7, /R0/PLUS (terminal), /D0/MINUS (terminal), /M12/S (terminal), /net034, /M2/D (terminal), /M4/S (terminal), /M7/D (terminal), /M8/D (terminal), /M10/S (terminal), /M11/S (terminal), /D0/PLUS (terminal), /net031, /D1/PLUS (terminal)
Run mode: Single Run, Sweeps and Corners
