ADE simulation setup
Run mode: Single Run, Sweeps and Corners
Tests:
  PTM_14nm_FKK:LED_Driver_Drived_Vt_Referenced:1: PTM_14nm_FKK/LED_Driver_Drived_Vt_Referenced/schematic, simulator spectre
