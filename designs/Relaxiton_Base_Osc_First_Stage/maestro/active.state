ADE simulation setup
Test PTM_14nm_FKK:Relaxiton_Base_Osc_First_Stage:1: PTM_14nm_FKK/Relaxiton_Base_Osc_First_Stage/schematic, simulator spectre
  Models: /home/work/PTM_14nm_FKK/nfet14nm.sp, /home/work/PTM_14nm_FKK/pfet14nm.sp
  Temperature: 27
  Analysis dc: sweep /V0.dc start=0 stop=0.8 (saves the operating point)
  Signals: /Vpos, /Vneg, /net7 as G1_Out, /net30 as G2_Out
Run mode: Single Run, Sweeps and Corners
