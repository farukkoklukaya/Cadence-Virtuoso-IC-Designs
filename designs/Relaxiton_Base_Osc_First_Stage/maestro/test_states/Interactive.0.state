ADE simulation setup
Test PTM_14nm_FKK:Relaxiton_Base_Osc_First_Stage:1: PTM_14nm_FKK/Relaxiton_Base_Osc_First_Stage/schematic, simulator spectre
  Temperature: 27
  Analysis dc: sweep /V0.dc start=0 stop=0.8 (saves the operating point)
  Signals: /Vpos, /Vneg, /net7 as G1_Out, /net30 as G2_Out
