ADE simulation setup
Run mode: Single Run, Sweeps and Corners
Tests:
  PTM_14nm_FKK:Relaxiton_Base_Osc_First_Stage:1: PTM_14nm_FKK/Relaxiton_Base_Osc_First_Stage/schematic, simulator spectre
