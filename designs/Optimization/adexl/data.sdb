ADE simulation setup
Run mode: Local Optimization
Tests:
  PTM_14nm_FKK:Optimization:1: PTM_14nm_FKK/Optimization/schematic, simulator spectre
    Outputs: VDC("/net05")
Device parameters:
  PTM_14nm_FKK/Optimization/schematic/M0.w = 500n:0.01u:5u
Specs:
  PTM_14nm_FKK:Optimization:1 / VDC("/net05"): range 0.745 to 0.755
