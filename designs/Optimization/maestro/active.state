ADE simulation setup
Test PTM_14nm_FKK:Optimization:1: PTM_14nm_FKK/Optimization/schematic, simulator spectre
  Models: /home/work/PTM_14nm_FKK/ibm130nm.sp
  Temperature: 27
  Analysis dc: (saves the operating point)
  Output Vout = VDC("/net05")
Run mode: Local Optimization
Device parameters:
  PTM_14nm_FKK/Optimization/schematic/M0.w = 500n:0.01u:5u
Specs:
  PTM_14nm_FKK:Optimization:1 / Vout: range 0.65 to 0.75
