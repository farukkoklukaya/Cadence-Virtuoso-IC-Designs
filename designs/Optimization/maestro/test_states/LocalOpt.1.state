ADE simulation setup
Test PTM_14nm_FKK:Optimization:1: PTM_14nm_FKK/Optimization/schematic, simulator spectre
  Models: /home/work/PTM_14nm_FKK/ibm130nm.sp
  Temperature: 27
  Analysis dc: (saves the operating point)
  Output Vout = VDC("/net05")
