ADE simulation setup
Run mode: Single Run, Sweeps and Corners
Tests:
  PTM_14nm_FKK:CS_Amplifier_Cascode:1: PTM_14nm_FKK/CS_Amplifier_Cascode/schematic, simulator spectre
