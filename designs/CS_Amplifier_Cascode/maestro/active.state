ADE simulation setup
Test PTM_14nm_FKK:CS_Amplifier_Cascode:1: PTM_14nm_FKK/CS_Amplifier_Cascode/schematic, simulator spectre
  Models: /home/work/gpdk090_v4.6/libs.oa22/gpdk090/../../models/spectre/gpdk090.scs[NN]
  Temperature: 27
  Analysis dc: sweep /V3.dc start=-1 stop=1 (saves the operating point)
  Analysis ac: start=100 stop=1G dec=20
  Analysis tran: stop=5m errpreset=moderate
  Signals: /Vin, /Vout
Run mode: Single Run, Sweeps and Corners
