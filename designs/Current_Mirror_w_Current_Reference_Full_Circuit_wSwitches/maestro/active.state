ADE simulation setup
Test PTM_14nm_FKK:Current_Mirror_w_Current_Reference_Full_Circuit_wSwitches:1: PTM_14nm_FKK/Current_Mirror_w_Current_Reference_Full_Circuit_wSwitches/schematic, simulator spectre
  Models: /home/work/PTM_14nm_FKK/led_model.scs, /home/work/PTM_14nm_FKK/tsmc018.scs
  Temperature: 27
  Analysis tran: stop=600u errpreset=moderate
  Signals: /M2/D (terminal), /M9/D (terminal), /M72/D (terminal), /D0/PLUS (terminal), /Sel0, /Sel1, /Sel2, /Sel3, /Sel4, /Sel5, /Sel6, /Sel7, /M10/D (terminal), /M18/D (terminal), /M11/D (terminal), /M21/D (terminal), /M60/D (terminal), /M22/D (terminal), /M14/D (terminal), /M66/D (terminal)
Run mode: Single Run, Sweeps and Corners
