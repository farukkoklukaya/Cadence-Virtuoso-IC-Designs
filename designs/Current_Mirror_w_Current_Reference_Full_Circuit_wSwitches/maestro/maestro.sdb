ADE simulation setup
Run mode: Single Run, Sweeps and Corners
Tests:
  PTM_14nm_FKK:Current_Mirror_w_Current_Reference_Full_Circuit_wSwitches:1: PTM_14nm_FKK/Current_Mirror_w_Current_Reference_Full_Circuit_wSwitches/schematic, simulator spectre
