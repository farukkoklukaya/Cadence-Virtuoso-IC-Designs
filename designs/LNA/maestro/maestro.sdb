ADE simulation setup
Run mode: Single Run, Sweeps and Corners
Tests:
  PTM_14nm_FKK:LNA:1: PTM_14nm_FKK/LNA/schematic, simulator spectre
    Outputs: aaSP("/PORT0" "/PORT0")
