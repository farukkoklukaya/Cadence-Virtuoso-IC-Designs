ADE simulation setup
Test PTM_14nm_FKK:LNA:1: PTM_14nm_FKK/LNA/schematic, simulator spectre
  Models: /home/work/gpdk090_v4.6/libs.oa22/gpdk090/../../models/spectre/gpdk090.scs[NN]
  Temperature: 27
  Analysis sp: start=100M stop=5G lin=50 ports=("/PORT0" "/PORT1")
  Analysis tran: stop=10n
  Analysis dc: (saves the operating point)
  Output aaSP("/PORT0" "/PORT0")
  Output VT("/net8")
  Output VT("/net9")
Run mode: Single Run, Sweeps and Corners
