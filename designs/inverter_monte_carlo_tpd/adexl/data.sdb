ADE simulation setup
Run mode: Monte Carlo Sampling
Tests:
  PTM_14nm_FKK:inverter_monte_carlo_tpd:1: PTM_14nm_FKK/inverter_monte_carlo_tpd/schematic, simulator spectre
    Outputs: tpd
Monte Carlo Sampling options: mcmethod=all, mcnumpoints=200
