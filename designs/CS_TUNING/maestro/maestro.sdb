ADE simulation setup
Run mode: Single Run, Sweeps and Corners
Tests:
  PTM_14nm_FKK:CS_TUNING:1: PTM_14nm_FKK/CS_TUNING/schematic, simulator spectre
    Variables: Vgg = 0.5; Vsin = 0.1m
