ADE simulation setup
Test PTM_14nm_FKK:CS_TUNING:1: PTM_14nm_FKK/CS_TUNING/schematic, simulator spectre
  Models: /home/work/gpdk090_v4.6/models/spectre/gpdk090.scs[NN]
  Variables: Vgg = 0.5; Vsin = 0.1m
  Temperature: 27
  Analysis tran: stop=2m errpreset=moderate
  Analysis dc: sweep Vgg start=0 stop=1 step=0.01 (saves the operating point)
  Output Vout = VT("/vout")
  Output Region = OP("/NM1" "region")
  Output Vth = OP("/NM1" "vth")
  Output Gm = OP("/NM1" "gm")
  Signals: /vout, /vin
Run mode: Single Run, Sweeps and Corners
