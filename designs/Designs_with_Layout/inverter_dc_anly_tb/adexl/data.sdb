ADE simulation setup
Run mode: Single Run, Sweeps and Corners
Tests:
  TUTORIAL_FKK:inverter_dc_anly_tb:1: TUTORIAL_FKK/inverter_dc_anly_tb/schematic, simulator spectre
Global variables:
  Wn = 120n
  Wp = 120n
Corners:
  model folders: /home/work/gpdk090_v4.6/models/spectre
  C0: temperature=-24,27,65; Wp=120n,240n,360n; gpdk090.scs[FF FS SF SS]
