ADE simulation setup
Run mode: Single Run, Sweeps and Corners
Tests:
  TUTORIAL_FKK:NOR_tb:1: TUTORIAL_FKK/NOR_tb/schematic, simulator spectre
