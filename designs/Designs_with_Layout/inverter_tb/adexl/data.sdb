ADE simulation setup
Run mode: Single Run, Sweeps and Corners
Tests:
  TUTORIAL_FKK:inverter_tb:1: TUTORIAL_FKK/inverter_tb/schematic, simulator spectre
