ADE simulation setup
Run mode: Single Run, Sweeps and Corners
Tests:
  PTM_14nm_FKK:NAND2_tb:1: PTM_14nm_FKK/NAND2_tb/schematic, simulator spectre
  PTM_14nm_FKK:NOT_TRANSIENT_TB:1: PTM_14nm_FKK/NOT_TRANSIENT_TB/schematic, simulator spectre
  PTM_14nm_FKK:NOT_DC_tb:1: PTM_14nm_FKK/NOT_DC_tb/schematic, simulator spectre
