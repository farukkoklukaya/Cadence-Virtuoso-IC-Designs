ADE simulation setup
Test PTM_14nm_FKK:NAND2_tb:1: PTM_14nm_FKK/NAND2_tb/schematic, simulator spectre
  Models: /home/work/PTM_14nm_FKK/pfet14nm.sp, /home/work/PTM_14nm_FKK/nfet14nm.sp
  Temperature: 27
  Analysis tran: stop=100n errpreset=moderate
  Signals: /A, /B, /Y
